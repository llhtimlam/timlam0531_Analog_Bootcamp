** sch_path: /mnt/c/Users/User/Documents/GitHub/timlam0531_Analog_Bootcamp/analog/schematics/tb_cmrr.sch
**.subckt tb_cmrr vout
*.opin vout
VDD VDD GND 1.8
VSS VSS GND 0
VCM net2 GND dc 0.9 ac 1
VDIFF net2 net4 0
R1 net3 net2 5000k m=1
R2 net1 net4 5000k m=1
x1 VDD vout net3 net1 VSS opamp_two_stage
**** begin user architecture code

.option scale=1u
.ac dec 10 1 100meg
.control
  run
  * Common-Mode Gain (Acm) profile
  let acm_db = db(v(vout))

  * CMRR = Adm_dB - Acm_dB
  let cmrr = 58.4 - acm_db

  plot cmrr
.endc

.param mc_mm_switch=0
.param mc_pr_switch=0
.include /home/user/.volare/sky130A/libs.tech/ngspice/corners/tt.spice
.include /home/user/.volare/sky130A/libs.tech/ngspice/r+c/res_typical__cap_typical.spice
.include /home/user/.volare/sky130A/libs.tech/ngspice/r+c/res_typical__cap_typical__lin.spice
.include /home/user/.volare/sky130A/libs.tech/ngspice/corners/tt/specialized_cells.spice

**** end user architecture code
**.ends

* expanding   symbol:  opamp_two_stage.sym # of pins=5
** sym_path: /mnt/c/Users/User/Documents/GitHub/timlam0531_Analog_Bootcamp/analog/schematics/opamp_two_stage.sym
** sch_path: /mnt/c/Users/User/Documents/GitHub/timlam0531_Analog_Bootcamp/analog/schematics/opamp_two_stage.sch
.subckt opamp_two_stage VDD vout VIN_P VIN_N VSS
*.ipin VIN_P
*.ipin VIN_N
*.opin vout
*.ipin VDD
*.ipin VSS
XM1 net3 VIN_N net4 VSS sky130_fd_pr__nfet_01v8 L=0.3 W=2 nf=1 ad='int((nf+1)/2) * W/nf * 0.29' as='int((nf+2)/2) * W/nf * 0.29' pd='2*int((nf+1)/2) * (W/nf + 0.29)'
+ ps='2*int((nf+2)/2) * (W/nf + 0.29)' nrd='0.29 / W' nrs='0.29 / W' sa=0 sb=0 sd=0 mult=1 m=1
XM2 net5 VIN_P net4 VSS sky130_fd_pr__nfet_01v8 L=0.3 W=2 nf=1 ad='int((nf+1)/2) * W/nf * 0.29' as='int((nf+2)/2) * W/nf * 0.29' pd='2*int((nf+1)/2) * (W/nf + 0.29)'
+ ps='2*int((nf+2)/2) * (W/nf + 0.29)' nrd='0.29 / W' nrs='0.29 / W' sa=0 sb=0 sd=0 mult=1 m=1
XM3 net3 net5 VDD VDD sky130_fd_pr__pfet_01v8 L=0.3 W=2 nf=1 ad='int((nf+1)/2) * W/nf * 0.29' as='int((nf+2)/2) * W/nf * 0.29' pd='2*int((nf+1)/2) * (W/nf + 0.29)'
+ ps='2*int((nf+2)/2) * (W/nf + 0.29)' nrd='0.29 / W' nrs='0.29 / W' sa=0 sb=0 sd=0 mult=1 m=1
XM4 net5 net5 VDD VDD sky130_fd_pr__pfet_01v8 L=0.3 W=2 nf=1 ad='int((nf+1)/2) * W/nf * 0.29' as='int((nf+2)/2) * W/nf * 0.29' pd='2*int((nf+1)/2) * (W/nf + 0.29)'
+ ps='2*int((nf+2)/2) * (W/nf + 0.29)' nrd='0.29 / W' nrs='0.29 / W' sa=0 sb=0 sd=0 mult=1 m=1
XM5 vout net3 VDD VDD sky130_fd_pr__pfet_01v8 L=0.3 W=2 nf=1 ad='int((nf+1)/2) * W/nf * 0.29' as='int((nf+2)/2) * W/nf * 0.29' pd='2*int((nf+1)/2) * (W/nf + 0.29)'
+ ps='2*int((nf+2)/2) * (W/nf + 0.29)' nrd='0.29 / W' nrs='0.29 / W' sa=0 sb=0 sd=0 mult=2 m=2
XM6 vout net1 VSS VSS sky130_fd_pr__nfet_01v8 L=1 W=3 nf=1 ad='int((nf+1)/2) * W/nf * 0.29' as='int((nf+2)/2) * W/nf * 0.29' pd='2*int((nf+1)/2) * (W/nf + 0.29)'
+ ps='2*int((nf+2)/2) * (W/nf + 0.29)' nrd='0.29 / W' nrs='0.29 / W' sa=0 sb=0 sd=0 mult=2 m=2
XM7 net4 net1 VSS VSS sky130_fd_pr__nfet_01v8 L=1 W=3 nf=1 ad='int((nf+1)/2) * W/nf * 0.29' as='int((nf+2)/2) * W/nf * 0.29' pd='2*int((nf+1)/2) * (W/nf + 0.29)'
+ ps='2*int((nf+2)/2) * (W/nf + 0.29)' nrd='0.29 / W' nrs='0.29 / W' sa=0 sb=0 sd=0 mult=2 m=2
XR1 net3 net2 VSS sky130_fd_pr__res_high_po W=1 L=1 mult=1 m=1
XC1 vout net2 sky130_fd_pr__cap_mim_m3_1 W=1 L=1 MF=1 m=1
XR2 net1 VDD VSS sky130_fd_pr__res_high_po W=1 L=1 mult=1 m=1
XR3 VSS net1 VSS sky130_fd_pr__res_high_po W=1 L=1 mult=1 m=1
.ends

.GLOBAL VDD
.GLOBAL GND
.GLOBAL VSS
.end
